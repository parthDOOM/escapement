* Layout art: no devices, no connections
.SUBCKT escapement_art
.ENDS escapement_art
